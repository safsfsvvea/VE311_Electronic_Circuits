** Profile: "SCHEMATIC1-sim"  [ D:\pspice\hw6\hw6-pspicefiles\schematic1\sim.sim ]

** Creating circuit file "sim.cir"
** WARNING: THIS AUTOMATICALLY GENERATED FILE MAY BE OVERWRITTEN BY SUBSEQUENT SIMULATIONS

*Libraries:
* Profile Libraries :
* Local Libraries :
.LIB "../../../hw6-pspicefiles/hw6.lib"
* From [PSPICE NETLIST] section of C:\Users\ZWK\AppData\Roaming\SPB_Data\cdssetup\OrCAD_PSpice\17.2.0\PSpice.ini file:
.lib "nomd.lib"

*Analysis directives:
.TRAN  0 0.1 0 0.00001
.OPTIONS ADVCONV
.PROBE64 V(alias(*)) I(alias(*)) W(alias(*)) D(alias(*)) NOISE(alias(*))
.INC "..\SCHEMATIC1.net"

.END
